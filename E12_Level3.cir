* E12 MOSFET ID-VDS - SPICE Level 3

.title E12 MOSFET ID-VDS - SPICE Level 3

.model NMOS3 NMOS LEVEL=3 VTO=-0.476 KP=1.381e-4 GAMMA=0.16685 PHI=0.7142

* VGS = 1 V
VDS1 d1 0 0
VGS1 g1 0 1
M1 d1 g1 0 0 NMOS3 W=4u L=0.18u

* VGS = 2 V
VDS2 d2 0 0
VGS2 g2 0 2
M2 d2 g2 0 0 NMOS3 W=4u L=0.18u

* VGS = 3 V
VDS3 d3 0 0
VGS3 g3 0 3
M3 d3 g3 0 0 NMOS3 W=4u L=0.18u

.control

dc VDS1 0 4 0.01
wrdata E12_Level3_VGS1.csv v(d1) i(VDS1)

dc VDS2 0 4 0.01
wrdata E12_Level3_VGS2.csv v(d2) i(VDS2)

dc VDS3 0 4 0.01
wrdata E12_Level3_VGS3.csv v(d3) i(VDS3)

.endc

.end
