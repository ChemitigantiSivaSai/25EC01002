* E12 MOSFET ID-VDS - SPICE Level 1

.title E12 MOSFET ID-VDS - SPICE Level 1

.model NMOS1 NMOS LEVEL=1 VTO=-0.476 KP=1.381e-4 GAMMA=0.16685 PHI=0.7142 LAMBDA=0

* VGS = 1 V
VDS1 d1 0 0
VGS1 g1 0 1
M1 d1 g1 0 0 NMOS1 W=4u L=0.18u

.dc VDS1 0 4 0.01

* VGS = 2 V
VDS2 d2 0 0
VGS2 g2 0 2
M2 d2 g2 0 0 NMOS1 W=4u L=0.18u

.dc VDS2 0 4 0.01

* VGS = 3 V
VDS3 d3 0 0
VGS3 g3 0 3
M3 d3 g3 0 0 NMOS1 W=4u L=0.18u

.dc VDS3 0 4 0.01

.control

* Run VGS = 1 V
dc VDS1 0 4 0.01
let ID1 = -i(VDS1)
wrdata E12_VGS1.csv v(d1) ID1

* Run VGS = 2 V
dc VDS2 0 4 0.01
let ID2 = -i(VDS2)
wrdata E12_VGS2.csv v(d2) ID2

* Run VGS = 3 V
dc VDS3 0 4 0.01
let ID3 = -i(VDS3)
wrdata E12_VGS3.csv v(d3) ID3

.endc

.end
